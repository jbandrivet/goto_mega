* Simulation Buck 36V -> 5V LM2596-5.0
Vin 1 0 DC 36
Vpulse 10 0 PULSE(0 1 0 10n 10n 0.93u 6.67u)

* Commutateur idéal modélisant le transistor de découpage interne du LM2596
S1 1 2 10 0 smod
.model smod sw(ron=0.08 roff=1meg vt=0.5 vh=0.1)

* Diode Schottky 1N5822 (Anode=0, Cathode=2)
D1 0 2 dmod
.model dmod d(is=1e-7 rs=0.03 n=1.05 bv=40 cjo=250p)

* Inductance 33uH avec résistance série de 0.04 Ohm
L1 2 3 33u
RL 3 4 0.04

* Condensateur de sortie 470uF avec ESR 0.04 Ohm
C1 4 5 470u
RC 5 0 0.04

* Condensateur céramique HF 100nF
Cdec 4 0 100n

* Charge 5 Ohms (1.0A sous 5V = consommation totale Teensy 4.1 + GPS + Raquette LCD)
Rload 4 0 5

* Analyse temporelle transitoire (0 à 2 millisecondes)
.tran 50n 2m uic
.control
run
wrdata /home/jean-baptiste/GotoAndrivet_PCB/simulation/buck_data.txt v(4)
quit
.endc
.end
